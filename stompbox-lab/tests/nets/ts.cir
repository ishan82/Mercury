* Screamer test
V1 VCC 0 9
V2 SRC 0 AC 1 SIN(0 0.2 440)
R1 SRC in 1k
C1 in a 22n
R2 a VB 1Meg
R3 VCC VB 10k
R4 VB 0 10k
XU1 a b VCC 0 opout TL072
R5 b c 4.7k
C2 c 0 47n
R6 opout b 51k
D1 opout b 1N4148
D2 b opout 1N4148
C3 opout out 1u
R7 out 0 100k
.model 1N4148 D(Is=2.52n N=1.752)
.end
